* sim1_boost_check.cir — boost near-steady-state verification
* IC=46V (close to 47.6V target) to skip slow RC ramp

.title LT8362 Boost — Near-Steady-State Check

Vin  vin 0 DC 5
RL1  vin l1a 40m
L1   l1a swnode 22u IC=0

Vpwm pwm 0 PULSE(0 5 0 5n 5n 1.713u 2.475u)
S1   swnode 0 pwm 0 SWMOD
.model SWMOD SW(RON=165m ROFF=1MEG VT=2.5 VH=0.5)

D1   swnode vout_raw SCHKY
.model SCHKY D(IS=5e-6 N=1.08 RS=0.08 CJO=80p BV=60)

RC9  vout_raw c9a 10m
C9   c9a 0 10u IC=46

Rload vout_raw 0 3k

.options method=gear reltol=1e-3 abstol=1e-9 itl4=100

.control
tran 10n 3m uic
meas tran vout_avg  avg v(vout_raw) from=2m to=3m
meas tran vout_pp   pp  v(vout_raw) from=2m to=3m
meas tran il_peak   max i(L1)       from=2m to=3m
meas tran il_min    min i(L1)       from=2m to=3m
echo ""
echo "=== Boost Converter Near-Steady-State ==="
echo "Vout_avg (V)  :" $&vout_avg
echo "Vout_pp  (V)  :" $&vout_pp
echo "IL_peak  (A)  :" $&il_peak
echo "IL_min   (A)  :" $&il_min
echo "L1 Isat       : 1.4A"
.endc
.end
